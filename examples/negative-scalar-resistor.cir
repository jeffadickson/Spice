Finite negative scalar resistance with a positive parallel load
V1 in 0 DC 2 AC 1
Rnegative in 0 -100
Rpositive in 0 200
.op
.dc V1 -1 1 .5
.ac lin 3 0 2000
.tran .1m 1m
.print dc v(in) i(V1)
.print ac v(in) i(V1)
.print tran v(in) i(V1)
.end

Bounded requested control example
V1 in 0 DC 0 AC 1 PWL(0 0 4u 4)
R1 in out 1k
R2 out 0 1k
.control
set noaskquit
op
dc V1 1 -1 -.5
ac dec 1 10 1k
tran .1u 1u
op
* Reporting is retained as an explicit unexecuted omission by the typed frontend.
print v(out)
quit
.endc
.end

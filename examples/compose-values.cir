Compose reporting qualification
V1 1 0 2.7
.control
op
compose vals values v(1) ln(2.7) log(2.7) log10(2.7)
compose gold values 2.7 0.9932517730102834 0.9932517730102834 0.43136376415898736
let err = vecmax(abs(vals/gold-1))
compose signed values 1 -2 3
compose copied values signed[0] signed[1]
compose goldsigned values (-1) 3
let errsigned = vecmax(abs(copied/goldsigned-1))
if err > 1e-15
quit 1
else
if errsigned > 1e-15
quit 1
else
quit 0
end
end
.endc
.end

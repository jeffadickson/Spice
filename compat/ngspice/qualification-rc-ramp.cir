Spice owned RC finite ramp qualification
V1 in 0 PWL(0,0,0.25,1,1,1)
R1 in out 2
C1 out 0 3
.tran 0.00390625 1
.print tran v(out)
.end

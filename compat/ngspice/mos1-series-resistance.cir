MOS1 drain and source resistance characterization
Vd d 0 2
Vg g 0 DC 2 AC 1
M1 d g 0 0 channel
.model channel nmos(level=1 l=1u w=20u vto=0.7 kp=100u rd=35 rs=25 cgso=2e-7 cgdo=1e-7)
.op
.dc Vg 0.5 3 0.25
.ac dec 4 1k 1meg
.end

Spice owned constant-charge diode transient qualification
.temp 27
.model DM D(IS=1u N=1 CJO=1u M=0 RS=0 TT=0)
V1 in 0 DC 0.1
R1 in out 1k
D1 out 0 DM
.tran 1u 5m UIC
.print tran v(out)
.end

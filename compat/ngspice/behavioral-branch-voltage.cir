Behavioral branch-current voltage
Vdrive in 0 DC 1 AC 1 PULSE(1 2 100n 1n 1n 500n 1u)
Rin in sense 1k
Bcopy out 0 V={I(Vsense)}
Vsense sense 0
Rload out 0 2k
.op
.ac dec 2 1 1k
.tran 1n 2u
.end

Independent PSpice switch signal transfer (ngspice bug883)
.include "bug883-vswitch.lib"
VDR IN 0 DC .1 AC 1
XU IN OUT DEMO
.save all
.ac lin 3 .99 1.01
.meas ac m_re FIND vr(OUT) AT=1
.meas ac m_im FIND vi(OUT) AT=1
.end

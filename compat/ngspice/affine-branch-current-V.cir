Affine branch current law
V1 a 0 DC 1 AC 1 PULSE(1 2 100n 1n 1n 500n 1u)
V2 b 0 DC 2 AC .5
R1 a 0 1k
R2 b 0 2k
Bcopy out 0 V={2*I(V1)-3*I(V2)+.25}
Rload out 0 1k
.op
.ac lin 1 100 100
.tran 1n 2u
.end

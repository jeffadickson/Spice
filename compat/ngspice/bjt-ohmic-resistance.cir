Level-1 NPN ohmic resistance characterization
Vc c 0 2
Vb b 0 DC 0.7 AC 1
Q1 c b 0 transistor
.model transistor npn(is=1e-15 bf=100 rb=100 rc=35 re=25 cje=2p cjc=1p)
.op
.dc Vb 0.55 0.8 0.025
.ac dec 4 1k 1meg
.end

JFET level 1 gate depletion ramp transient
VCC supply 0 5
VDRV drive 0 DC -2 AC 1 PWL(0 -2 20n -1.98 40n -1.98)
RG drive gate 1k
RL supply drain 1k
J1 drain gate 0 JQ
.model JQ NJF (LEVEL=1 VTO=-3.5 BETA=410u LAMBDA=.002 RD=200 CGS=3p CGD=2p PB=.9 FC=.4)
.op
.tran 5p 40n 0 5p
.end

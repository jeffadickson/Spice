Spice owned explicit constant-charge diode AC qualification
.temp 27
.model DM D(IS=1u N=1 CJO=1u M=0 RS=0 TT=0)
V1 in 0 DC 0 AC 1.118033988749895 26.56505117707799
R1 in out 1k
D1 out 0 DM
.ac dec 1 100 10000
.print ac v(out)
.end

Spice owned VCCS reactive load complex excitation qualification
V1 in 0 DC 0 AC 1.4577379737113252 120.96375653207352
RIN in 0 1k
G1 out 0 in 0 0.002
RLOAD out 0 1k
CLOAD out 0 1u
.ac dec 1 10 1000
.print ac v(out)
.end
